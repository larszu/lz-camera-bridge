* New stage, same supply sweep: does the stop move with the 9 V?
.include opamp.lib
V9   v9 0 9
VB   dacb 0 1.65
VC   dacc 0 1.65
Vri  zrefi 0 5.0
Rref zrefi zref 1k
R20  dacc zn 100k
R21  zn zout 180k
R22  dacb zp 100k
R23  zp zref 180k
X2 zp zn zout v9 0 OPA
R24  zout zpin 1.2k
Vneu zint 0 5.0
Rint zint zpin 10k
.control
dc V9 8.4 9.6 0.1
wrdata zoom_new_supply.dat v(zpin) v(zout)
.endc
.end
